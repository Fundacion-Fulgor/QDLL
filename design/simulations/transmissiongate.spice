** sch_path: /home/mateo/GitRepos/IVAN-EAMTA2026/design/blocks/transmissiongate/schematic/transmissiongate.sch
**.subckt transmissiongate a_neg out in vdd vss a_pos
*.iopin vdd
*.iopin vss
*.iopin out
*.iopin in
*.iopin a_neg
*.iopin a_pos
XM0 in a_neg out vdd sg13_lv_pmos w=2.0u l=0.13u ng=1 m=1
XM1 out a_pos in vss sg13_lv_nmos w=1.0u l=0.13u ng=1 m=1
**.ends
.end
