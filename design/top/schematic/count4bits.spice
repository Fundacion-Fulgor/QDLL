* NGSPICE netlist for count4bits - IHP SG13G2 PDK
* 4-bit synchronous binary counter
* Generated from count4bits.sch (hierarchical)
*
* Ports: CE vdd vss CLK CLR Q[0..3] outputs labeled 00,01,10,11

* Include lower-level blocks
.include ../count1bit/schematic/count1bit.spice

* Subcircuit port order from schematic:
*   count1bit: vss CE Dn CLK CLR vdd Sout
* Stage 0 (LSB): CE=always enabled (tied to vdd)
* Stage N: CE=carry-out from stage N-1

.subckt count4bits vdd vss CE CLK CLR Q0 Q1 Q2 Q3
* Stage 0 (LSB): CE = input CE (or vdd to always count)
Xs0 vss CE   Q0 CLK CLR vdd CO0 count1bit
* Stage 1: CE = CO0
Xs1 vss CO0  Q1 CLK CLR vdd CO1 count1bit
* Stage 2: CE = CO1
Xs2 vss CO1  Q2 CLK CLR vdd CO2 count1bit
* Stage 3 (MSB): CE = CO2
Xs3 vss CO2  Q3 CLK CLR vdd CO3 count1bit
.ends count4bits
