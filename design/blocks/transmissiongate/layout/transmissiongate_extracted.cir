* Extracted by KLayout with SG13G2 LVS runset on : 06/03/2026 18:58

.SUBCKT transmissiongate VSS VDD VCTRLN VIN VOUT VCTRLP
M$1 VIN VCTRLN VOUT VSS sg13_lv_nmos L=0.13u W=0.15u AS=0.1005p AD=0.1005p
+ PS=1.34u PD=1.34u
M$2 VIN VCTRLP VOUT VDD sg13_lv_pmos L=0.13u W=0.3u AS=0.156p AD=0.156p
+ PS=2.08u PD=2.08u
.ENDS transmissiongate
