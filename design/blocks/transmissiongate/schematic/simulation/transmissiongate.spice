** sch_path: /home/mateo/GitRepos/EAMTA2026-VLSI/design/blocks/transmissiongate/schematic/transmissiongate.sch
.subckt transmissiongate VCTRLN VSS VOUT VIN VDD VCTRLP
*.PININFO VCTRLN:B VCTRLP:B VOUT:O VIN:I VSS:B VDD:B
M1 VOUT VCTRLN VIN VSS sg13_lv_nmos w=0.15u l=0.13u ng=1
M2 VOUT VCTRLP VIN VDD sg13_lv_pmos w=0.15u l=0.13u ng=1 m=2
.ends
