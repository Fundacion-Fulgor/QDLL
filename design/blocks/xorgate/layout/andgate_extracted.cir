* Extracted by KLayout with SG13G2 LVS runset on : 06/03/2026 21:09

.SUBCKT andgate VSS VOUT VB VA VDD
X$1 \$9 VDD VA VB VSS nandgate
M$1 VDD \$9 VOUT VDD sg13_lv_pmos L=0.13u W=0.3u AS=0.102p AD=0.102p PS=1.28u
+ PD=1.28u
M$2 VSS \$9 VOUT VSS sg13_lv_nmos L=0.13u W=0.15u AS=0.1005p AD=0.1005p
+ PS=1.34u PD=1.34u
.ENDS andgate

.SUBCKT nandgate \$1 VDD VA VB VSS
M$1 \$2 VA \$1 VSS sg13_lv_nmos L=0.13u W=0.15u AS=0.11325p AD=0.1005p PS=1.07u
+ PD=1.34u
M$2 VSS VB \$2 VSS sg13_lv_nmos L=0.13u W=0.45u AS=0.153p AD=0.11325p PS=1.58u
+ PD=1.07u
M$3 VDD VB \$1 VDD sg13_lv_pmos L=0.13u W=0.15u AS=0.1005p AD=0.0825p PS=1.34u
+ PD=0.92u
M$4 \$1 VA VDD VDD sg13_lv_pmos L=0.13u W=0.15u AS=0.0825p AD=0.1005p PS=0.92u
+ PD=1.34u
.ENDS nandgate
