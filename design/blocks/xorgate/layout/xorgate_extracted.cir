* Extracted by KLayout with SG13G2 LVS runset on : 06/03/2026 21:19

.SUBCKT xorgate VSS VDD VIN VIN$1 B|VB|VIN VA|VOUT VB|VOUT A|VA|VIN VA|VOUT$1
+ VIN|VOUT OUT|VOUT VB|VOUT$1
M$1 \$15 VA|VOUT VIN VSS sg13_lv_nmos L=0.13u W=0.15u AS=0.11325p AD=0.1005p
+ PS=1.07u PD=1.34u
M$2 VSS B|VB|VIN \$15 VSS sg13_lv_nmos L=0.13u W=0.45u AS=0.153p AD=0.11325p
+ PS=1.58u PD=1.07u
M$3 \$17 A|VA|VIN VIN$1 VSS sg13_lv_nmos L=0.13u W=0.15u AS=0.11325p AD=0.1005p
+ PS=1.07u PD=1.34u
M$4 VSS VB|VOUT \$17 VSS sg13_lv_nmos L=0.13u W=0.45u AS=0.153p AD=0.11325p
+ PS=1.58u PD=1.07u
M$5 VSS VIN VA|VOUT$1 VSS sg13_lv_nmos L=0.13u W=0.15u AS=0.1005p AD=0.1005p
+ PS=1.34u PD=1.34u
M$6 VSS VIN$1 VB|VOUT$1 VSS sg13_lv_nmos L=0.13u W=0.15u AS=0.1005p AD=0.1005p
+ PS=1.34u PD=1.34u
M$7 VSS VIN|VOUT OUT|VOUT VSS sg13_lv_nmos L=0.13u W=0.15u AS=0.1005p
+ AD=0.1005p PS=1.34u PD=1.34u
M$8 VSS A|VA|VIN VA|VOUT VSS sg13_lv_nmos L=0.13u W=0.15u AS=0.1005p AD=0.1005p
+ PS=1.34u PD=1.34u
M$9 VB|VOUT B|VB|VIN VSS VSS sg13_lv_nmos L=0.13u W=0.15u AS=0.1005p AD=0.1005p
+ PS=1.34u PD=1.34u
M$10 VSS VA|VOUT$1 VIN|VOUT VSS sg13_lv_nmos L=0.13u W=0.15u AS=0.1005p
+ AD=0.0825p PS=1.34u PD=0.92u
M$11 VIN|VOUT VB|VOUT$1 VSS VSS sg13_lv_nmos L=0.13u W=0.15u AS=0.0825p
+ AD=0.1005p PS=0.92u PD=1.34u
M$12 VDD B|VB|VIN VIN VDD sg13_lv_pmos L=0.13u W=0.15u AS=0.1005p AD=0.0825p
+ PS=1.34u PD=0.92u
M$13 VIN VA|VOUT VDD VDD sg13_lv_pmos L=0.13u W=0.15u AS=0.0825p AD=0.1005p
+ PS=0.92u PD=1.34u
M$14 VDD VB|VOUT VIN$1 VDD sg13_lv_pmos L=0.13u W=0.15u AS=0.1005p AD=0.0825p
+ PS=1.34u PD=0.92u
M$15 VIN$1 A|VA|VIN VDD VDD sg13_lv_pmos L=0.13u W=0.15u AS=0.0825p AD=0.1005p
+ PS=0.92u PD=1.34u
M$16 VDD VIN VA|VOUT$1 VDD sg13_lv_pmos L=0.13u W=0.3u AS=0.102p AD=0.102p
+ PS=1.28u PD=1.28u
M$17 VDD VIN$1 VB|VOUT$1 VDD sg13_lv_pmos L=0.13u W=0.3u AS=0.102p AD=0.102p
+ PS=1.28u PD=1.28u
M$18 VDD A|VA|VIN VA|VOUT VDD sg13_lv_pmos L=0.13u W=0.3u AS=0.102p AD=0.102p
+ PS=1.28u PD=1.28u
M$19 VDD VIN|VOUT OUT|VOUT VDD sg13_lv_pmos L=0.13u W=0.3u AS=0.102p AD=0.102p
+ PS=1.28u PD=1.28u
M$20 VB|VOUT B|VB|VIN VDD VDD sg13_lv_pmos L=0.13u W=0.3u AS=0.102p AD=0.102p
+ PS=1.28u PD=1.28u
M$21 VDD VA|VOUT$1 \$37 VDD sg13_lv_pmos L=0.13u W=0.15u AS=0.1005p AD=0.0825p
+ PS=1.34u PD=0.92u
M$22 \$37 VB|VOUT$1 VIN|VOUT VDD sg13_lv_pmos L=0.13u W=0.15u AS=0.0825p
+ AD=0.1005p PS=0.92u PD=1.34u
.ENDS xorgate
