* Extracted by KLayout with SG13G2 LVS runset on : 06/03/2026 20:07

.SUBCKT orgate VSS VA VB VIN VOUT VDD
X$4 VSS VDD VIN VOUT inverter
X$5 VSS VIN VA VB VDD norgate
.ENDS orgate

.SUBCKT inverter VSS VDD VIN VOUT
M$1 VDD VIN VOUT VDD sg13_lv_pmos L=0.13u W=0.3u AS=0.102p AD=0.102p PS=1.28u
+ PD=1.28u
M$2 VSS VIN VOUT VSS sg13_lv_nmos L=0.13u W=0.15u AS=0.1005p AD=0.1005p
+ PS=1.34u PD=1.34u
.ENDS inverter

.SUBCKT norgate VSS VOUT VA VB VDD
M$1 VSS VB VOUT VSS sg13_lv_nmos L=0.13u W=0.15u AS=0.1005p AD=0.0825p PS=1.34u
+ PD=0.92u
M$2 VOUT VA VSS VSS sg13_lv_nmos L=0.13u W=0.15u AS=0.0825p AD=0.1005p PS=0.92u
+ PD=1.34u
M$3 VOUT VB \$2 VDD sg13_lv_pmos L=0.13u W=0.15u AS=0.1005p AD=0.0825p PS=1.34u
+ PD=0.92u
M$4 \$2 VA VDD VDD sg13_lv_pmos L=0.13u W=0.15u AS=0.0825p AD=0.1005p PS=0.92u
+ PD=1.34u
.ENDS norgate
