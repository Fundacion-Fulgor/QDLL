* NGSPICE netlist for dff - IHP SG13G2 PDK
* D Flip-Flop with clear (positive edge-triggered, master-slave)
* Generated from dff.sch (hierarchical)
*
* Uses subcircuits: inverter, norgate, transmissiongate

* Include lower-level blocks
.include ../inverter/schematic/inverter.spice
.include ../norgate/schematic/norgate.spice
.include ../transmissiongate/schematic/transmissiongate.spice

.subckt dff vdd vss D CLK CLR Q Qb
* Clock buffer - generate clk_pos and clk_neg
Xinv_clk vdd CLK vss clk_neg inverter
Xinv_clk2 vdd clk_neg vss clk_pos inverter

* Master latch (transparent when CLK=1 i.e. clk_pos=1)
Xtg1 vdd vss D master_in clk_neg clk_pos transmissiongate
Xnor1 vdd master_in CLR vss master_fb norgate
Xtg2 vdd vss master_fb master_in clk_pos clk_neg transmissiongate
Xinv_m vdd master_in vss master_out inverter

* Slave latch (transparent when CLK=0 i.e. clk_neg=1)
Xtg3 vdd vss master_out slave_in clk_pos clk_neg transmissiongate
Xnor2 vdd slave_in CLR vss slave_fb norgate
Xtg4 vdd vss slave_fb slave_in clk_neg clk_pos transmissiongate
Xinv_q vdd slave_in vss Q inverter
Xinv_qb vdd Q vss Qb inverter
.ends dff
