* Extracted by KLayout with SG13G2 LVS runset on : 06/03/2026 16:33

.SUBCKT dff VSS VDD VIN|VOUT Qb|VIN VCTRLP VOUT VB VOUT$1 VCTRLN VOUT$2 D|VIN
+ VA|VIN VA|VOUT CLK VDD$1
M$1 VOUT$2 VCTRLN VIN|VOUT VSS sg13_lv_nmos L=0.13u W=0.15u AS=0.1005p
+ AD=0.1005p PS=1.34u PD=1.34u
M$2 VOUT VCTRLN Qb|VIN VSS sg13_lv_nmos L=0.13u W=0.15u AS=0.1005p AD=0.1005p
+ PS=1.34u PD=1.34u
M$3 VCTRLP VCTRLN VSS VSS sg13_lv_nmos L=0.13u W=0.15u AS=0.1005p AD=0.1005p
+ PS=1.34u PD=1.34u
M$4 Qb|VIN VOUT$1 VSS VSS sg13_lv_nmos L=0.13u W=0.15u AS=0.1005p AD=0.1005p
+ PS=1.34u PD=1.34u
M$5 VSS VB VIN|VOUT VSS sg13_lv_nmos L=0.13u W=0.15u AS=0.1005p AD=0.0825p
+ PS=1.34u PD=0.92u
M$6 VIN|VOUT VA|VIN VSS VSS sg13_lv_nmos L=0.13u W=0.15u AS=0.0825p AD=0.1005p
+ PS=0.92u PD=1.34u
M$7 VSS VA|VOUT VOUT$1 VSS sg13_lv_nmos L=0.13u W=0.15u AS=0.1005p AD=0.0825p
+ PS=1.34u PD=0.92u
M$8 VOUT$1 VB VSS VSS sg13_lv_nmos L=0.13u W=0.15u AS=0.0825p AD=0.1005p
+ PS=0.92u PD=1.34u
M$9 VSS CLK VCTRLN VSS sg13_lv_nmos L=0.13u W=0.15u AS=0.1005p AD=0.1005p
+ PS=1.34u PD=1.34u
M$10 VSS VOUT$2 VA|VIN VSS sg13_lv_nmos L=0.13u W=0.15u AS=0.1005p AD=0.1005p
+ PS=1.34u PD=1.34u
M$11 D|VIN VCTRLN VOUT$2 VSS sg13_lv_nmos L=0.13u W=0.15u AS=0.1005p AD=0.1005p
+ PS=1.34u PD=1.34u
M$12 VA|VIN VCTRLN VA|VOUT VSS sg13_lv_nmos L=0.13u W=0.15u AS=0.1005p
+ AD=0.1005p PS=1.34u PD=1.34u
M$13 VIN|VOUT VB \$6 VDD sg13_lv_pmos L=0.13u W=0.15u AS=0.1005p AD=0.0825p
+ PS=1.34u PD=0.92u
M$14 \$6 VA|VIN VDD VDD sg13_lv_pmos L=0.13u W=0.15u AS=0.0825p AD=0.1005p
+ PS=0.92u PD=1.34u
M$15 VIN|VOUT VCTRLP VOUT$2 VDD sg13_lv_pmos L=0.13u W=0.3u AS=0.156p AD=0.156p
+ PS=2.08u PD=2.08u
M$17 Qb|VIN VCTRLP VOUT VDD sg13_lv_pmos L=0.13u W=0.3u AS=0.156p AD=0.156p
+ PS=2.08u PD=2.08u
M$19 VCTRLP VCTRLN VDD VDD sg13_lv_pmos L=0.13u W=0.3u AS=0.102p AD=0.102p
+ PS=1.28u PD=1.28u
M$20 Qb|VIN VOUT$1 VDD VDD sg13_lv_pmos L=0.13u W=0.3u AS=0.102p AD=0.102p
+ PS=1.28u PD=1.28u
M$21 VDD$1 CLK VCTRLN VDD$1 sg13_lv_pmos L=0.13u W=0.3u AS=0.102p AD=0.102p
+ PS=1.28u PD=1.28u
M$22 VDD$1 VOUT$2 VA|VIN VDD$1 sg13_lv_pmos L=0.13u W=0.3u AS=0.102p AD=0.102p
+ PS=1.28u PD=1.28u
M$23 D|VIN VCTRLP VOUT$2 VDD$1 sg13_lv_pmos L=0.13u W=0.3u AS=0.156p AD=0.156p
+ PS=2.08u PD=2.08u
M$25 VA|VIN VCTRLP VA|VOUT VDD$1 sg13_lv_pmos L=0.13u W=0.3u AS=0.156p
+ AD=0.156p PS=2.08u PD=2.08u
M$27 VDD$1 VA|VOUT \$47 VDD$1 sg13_lv_pmos L=0.13u W=0.15u AS=0.1005p
+ AD=0.0825p PS=1.34u PD=0.92u
M$28 \$47 VB VOUT$1 VDD$1 sg13_lv_pmos L=0.13u W=0.15u AS=0.0825p AD=0.1005p
+ PS=0.92u PD=1.34u
.ENDS dff
