* NGSPICE netlist for count1bit - IHP SG13G2 PDK
* 1-bit counter stage
* Generated from count1bit.sch (hierarchical)
*
* Logic: D = Dn XOR CE  (toggle when CE=1)
*        Sout = Dn AND CE  (carry out when Q=1 and EN=1)
*
* Ports: vss CE Dn CLK CLR vdd Sout
*   Dn   = current counter bit value (Q output, also feeds back to XOR/AND)
*   CE   = count enable / carry in
*   Sout = carry out to next stage

* Include lower-level blocks
.include ../xorgate/schematic/xorgate.spice
.include ../andgate/schematic/andgate.spice
.include ../dff/schematic/dff.spice

.subckt count1bit vss CE Dn CLK CLR vdd Sout
* XOR gate: next_D = Dn XOR CE
Xxor vdd vss Dn CE next_D xorgate
* D Flip-Flop: latch next_D, produce Dn (Q) and Dn_b (Qb)
Xdff vdd vss next_D CLK CLR Dn Dn_b dff
* AND gate: carry out = Dn AND CE
Xand vdd Dn CE vss Sout andgate
.ends count1bit
